* NGSPICE file created from tt_um_armohamed_r2rvc.ext - technology: sky130A

.subckt arm_r2rvc_lsbufhv2lv A LVPWR VGND VNB VPB VPWR X a_389_141# a_30_1337# a_30_207#
+ a_389_1337#
X0 a_30_1337# A VPWR VPB sky130_fd_pr__pfet_g5v0d10v5 ad=0.1113 pd=1.37 as=0.1197 ps=1.41 w=0.42 l=0.5
X1 VGND a_389_141# X VNB sky130_fd_pr__nfet_01v8 ad=0.1961 pd=2.01 as=0.1961 ps=2.01 w=0.74 l=0.15
X2 VGND a_30_1337# a_30_207# VNB sky130_fd_pr__nfet_g5v0d10v5 ad=0.17887 pd=1.26 as=0.1197 ps=1.41 w=0.42 l=0.5
X3 LVPWR a_389_1337# a_389_141# LVPWR sky130_fd_pr__pfet_01v8_hvt ad=0.2968 pd=2.77 as=0.2968 ps=2.77 w=1.12 l=0.15
X4 a_389_1337# a_389_141# LVPWR LVPWR sky130_fd_pr__pfet_01v8_hvt ad=0.2968 pd=2.77 as=0.1568 ps=1.4 w=1.12 l=0.15
X5 VGND a_30_207# a_389_141# VNB sky130_fd_pr__nfet_g5v0d10v5 ad=0.19875 pd=2.03 as=0.105 ps=1.03 w=0.75 l=0.5
X6 a_389_1337# a_30_1337# VGND VNB sky130_fd_pr__nfet_g5v0d10v5 ad=0.49875 pd=2.83 as=0.105 ps=1.03 w=0.75 l=0.5
X7 VGND a_30_207# a_389_141# VNB sky130_fd_pr__nfet_g5v0d10v5 ad=0.19875 pd=2.03 as=0.19875 ps=2.03 w=0.75 l=0.5
X8 VGND a_30_207# a_389_141# VNB sky130_fd_pr__nfet_g5v0d10v5 ad=0.19875 pd=2.03 as=0.19875 ps=2.03 w=0.75 l=0.5
X9 VGND A a_30_1337# VNB sky130_fd_pr__nfet_g5v0d10v5 ad=0.17887 pd=1.26 as=0.1197 ps=1.41 w=0.42 l=0.5
X10 VGND a_30_1337# a_389_1337# VNB sky130_fd_pr__nfet_g5v0d10v5 ad=0.19875 pd=2.03 as=0.19875 ps=2.03 w=0.75 l=0.5
X11 a_389_141# a_30_207# VGND VNB sky130_fd_pr__nfet_g5v0d10v5 ad=0.105 pd=1.03 as=0.17887 ps=1.26 w=0.75 l=0.5
X12 VGND a_30_1337# a_389_1337# VNB sky130_fd_pr__nfet_g5v0d10v5 ad=0.105 pd=1.03 as=0.105 ps=1.03 w=0.75 l=0.5
X13 a_389_1337# a_30_1337# VGND VNB sky130_fd_pr__nfet_g5v0d10v5 ad=0.105 pd=1.03 as=0.17887 ps=1.26 w=0.75 l=0.5
X14 LVPWR a_389_141# X LVPWR sky130_fd_pr__pfet_01v8_hvt ad=0.1568 pd=1.4 as=0.2968 ps=2.77 w=1.12 l=0.15
X15 a_30_207# a_30_1337# VPWR VPB sky130_fd_pr__pfet_g5v0d10v5 ad=0.1113 pd=1.37 as=0.1197 ps=1.41 w=0.42 l=0.5
C0 a_389_1337# X 0
C1 a_30_207# VPWR 0.04031f
C2 VPB VGND 0.04165f
C3 a_389_141# X 0.1595f
C4 VPWR VGND 0.18667f
C5 a_389_1337# a_30_1337# 0.25126f
C6 a_389_141# a_30_1337# 0.16545f
C7 VPB VPWR 2.2049f
C8 LVPWR X 0.20425f
C9 a_389_1337# A 0.00352f
C10 a_30_207# X 0
C11 a_389_141# A 0
C12 X VGND 0.25175f
C13 LVPWR a_30_1337# 0.06819f
C14 a_30_207# a_30_1337# 0.17026f
C15 LVPWR A 0.002f
C16 VPB X 0.00246f
C17 VGND a_30_1337# 0.29682f
C18 VPWR X 0.00748f
C19 a_389_1337# a_389_141# 0.14819f
C20 A VGND 0.03611f
C21 VPB a_30_1337# 0.2996f
C22 VPWR a_30_1337# 0.21584f
C23 LVPWR a_389_1337# 0.44352f
C24 VPB A 0.19391f
C25 LVPWR a_389_141# 0.40378f
C26 a_30_207# a_389_1337# 0
C27 VPWR A 0.09009f
C28 a_30_207# a_389_141# 0.24859f
C29 a_389_1337# VGND 0.37351f
C30 a_389_141# VGND 0.37841f
C31 X a_30_1337# 0
C32 a_389_1337# VPB 0.05283f
C33 a_30_207# LVPWR 0.03279f
C34 a_389_1337# VPWR 0.1225f
C35 a_389_141# VPB 0.08458f
C36 LVPWR VGND 0.24773f
C37 a_389_141# VPWR 0.18487f
C38 a_30_207# VGND 0.25431f
C39 LVPWR VPB 0.09556f
C40 A a_30_1337# 0.18713f
C41 LVPWR VPWR 1.12268f
C42 a_30_207# VPB 0.04772f
C43 X VNB 0.11101f
C44 VPWR VNB 0.3039f
C45 VGND VNB 2.87621f
C46 A VNB 0.28536f
C47 LVPWR VNB 0.71958f
C48 VPB VNB 1.88193f
C49 a_30_207# VNB 0.66569f
C50 a_389_141# VNB 0.77447f
C51 a_389_1337# VNB 0.55786f
C52 a_30_1337# VNB 1.03826f
.ends

.subckt comparator_bias a_512471_648367# a_508011_647837# a_508013_648897# VBP VBN
+ a_508011_646777# a_508011_646247# a_512471_647307# a_512471_646247# VDD VSS a_513709_648116#
X0 a_508011_647837# a_512471_647307# VDD sky130_fd_pr__res_high_po_1p41 l=20.3
X1 a_508011_646777# a_512471_646247# VDD sky130_fd_pr__res_high_po_1p41 l=20.3
X2 VSS VSS VBP VSS sky130_fd_pr__nfet_g5v0d10v5 ad=1.45 pd=10.58 as=0.725 ps=5.29 w=5 l=2
X3 VSS VSS a_513709_648116# VSS sky130_fd_pr__nfet_g5v0d10v5 ad=0.725 pd=5.29 as=0.725 ps=5.29 w=5 l=2
X4 VDD VBP VBP VDD sky130_fd_pr__pfet_g5v0d10v5 ad=1.45 pd=10.58 as=1.45 ps=10.58 w=5 l=2
X5 a_508011_646777# a_512471_647307# VDD sky130_fd_pr__res_high_po_1p41 l=20.3
X6 a_513709_648116# a_508011_646247# VDD VDD sky130_fd_pr__pfet_g5v0d10v5 ad=0.725 pd=5.29 as=1.45 ps=10.58 w=5 l=2
X7 a_508011_646247# a_512471_646247# VDD sky130_fd_pr__res_high_po_1p41 l=20.3
X8 VBP VBN VSS VSS sky130_fd_pr__nfet_g5v0d10v5 ad=0.725 pd=5.29 as=0.725 ps=5.29 w=5 l=2
X9 a_508011_647837# a_512471_648367# VDD sky130_fd_pr__res_high_po_1p41 l=20.3
X10 VBN a_513709_648116# a_508011_646247# VDD sky130_fd_pr__pfet_g5v0d10v5 ad=0.725 pd=5.29 as=1.45 ps=10.58 w=5 l=2
X11 a_513709_648116# a_508011_646247# VDD VDD sky130_fd_pr__pfet_g5v0d10v5 ad=0.725 pd=5.29 as=0.725 ps=5.29 w=5 l=2
X12 a_508013_648897# a_512471_648367# VDD sky130_fd_pr__res_high_po_1p41 l=20.3
X13 VBN a_513709_648116# a_508011_646247# VDD sky130_fd_pr__pfet_g5v0d10v5 ad=0.725 pd=5.29 as=0.725 ps=5.29 w=5 l=2
X14 VSS VBN VBN VSS sky130_fd_pr__nfet_g5v0d10v5 ad=0.725 pd=5.29 as=0.725 ps=5.29 w=5 l=2
X15 VDD a_508011_646247# a_513709_648116# VDD sky130_fd_pr__pfet_g5v0d10v5 ad=0.725 pd=5.29 as=0.725 ps=5.29 w=5 l=2
X16 VDD a_508011_646247# a_513709_648116# VDD sky130_fd_pr__pfet_g5v0d10v5 ad=1.45 pd=10.58 as=0.725 ps=5.29 w=5 l=2
X17 a_508011_646247# a_513709_648116# VBN VDD sky130_fd_pr__pfet_g5v0d10v5 ad=0.725 pd=5.29 as=0.725 ps=5.29 w=5 l=2
X18 VBN VSS VSS VSS sky130_fd_pr__nfet_g5v0d10v5 ad=0.725 pd=5.29 as=1.45 ps=10.58 w=5 l=2
X19 a_513709_648116# VBN VSS VSS sky130_fd_pr__nfet_g5v0d10v5 ad=0.725 pd=5.29 as=0.725 ps=5.29 w=5 l=2
X20 a_508011_646247# a_513709_648116# VBN VDD sky130_fd_pr__pfet_g5v0d10v5 ad=1.45 pd=10.58 as=0.725 ps=5.29 w=5 l=2
X21 VBN VBN a_508011_646247# VDD sky130_fd_pr__pfet_g5v0d10v5 ad=0.29 pd=2.58 as=0.29 ps=2.58 w=1 l=15
X22 a_508013_648897# VDD VDD sky130_fd_pr__res_high_po_1p41 l=20.3
C0 VBP a_513709_648116# 0.05283f
C1 a_508011_646247# a_513709_648116# 3.67519f
C2 a_508011_646247# a_508011_646777# 0.17613f
C3 VDD a_512471_648367# 0.7006f
C4 VDD a_512471_646247# 0.62591f
C5 a_508013_648897# a_508011_647837# 0.13939f
C6 a_508011_646777# a_508011_647837# 0.1399f
C7 a_512471_647307# VDD 0.52166f
C8 VBP VDD 4.43455f
C9 a_512471_647307# a_512471_648367# 0.13991f
C10 VBN a_513709_648116# 3.8919f
C11 a_512471_647307# a_512471_646247# 0.1399f
C12 a_508011_646247# VDD 8.28188f
C13 a_508011_646247# a_512471_648367# 0.00848f
C14 a_508011_646247# a_512471_646247# 0.17493f
C15 a_508011_646247# a_512471_647307# 0.03992f
C16 VDD a_508011_647837# 0.36779f
C17 VBP a_508011_646247# 0.17121f
C18 VBN VDD 5.40262f
C19 a_508011_646247# a_508011_647837# 0.00243f
C20 VBP VBN 0.89793f
C21 a_508011_646247# VBN 3.26041f
C22 a_508013_648897# a_508011_646777# 0
C23 a_513709_648116# VDD 4.15273f
C24 a_508013_648897# VDD 0.47148f
C25 a_508011_646777# VDD 0.36767f
C26 a_512471_647307# a_513709_648116# 0
C27 a_512471_646247# VSS 0.76689f
C28 a_508011_646777# VSS 0.83516f
C29 VBP VSS 2.94874f
C30 a_513709_648116# VSS 3.86727f
C31 a_508011_646247# VSS 5.38609f
C32 VBN VSS 12.4474f
C33 a_512471_647307# VSS 0.72428f
C34 a_508011_647837# VSS 0.83555f
C35 a_512471_648367# VSS 0.71741f
C36 a_508013_648897# VSS 0.88419f
C37 VDD VSS 0.10463p
.ends

.subckt comparator a_509430_640243# a_512178_643337# a_509430_644503# a_508972_641405#
+ VBP a_512178_641405# VBN VINP a_509030_644406# a_509030_640217# VINM a_515760_641405#
+ VDD VSS VOUT a_512178_640243# a_508972_643337#
X0 VDD VDD VDD VDD sky130_fd_pr__pfet_g5v0d10v5 ad=0.725 pd=5.29 as=29 ps=211.02 w=5 l=2
X1 VSS VSS VSS VSS sky130_fd_pr__nfet_g5v0d10v5 ad=0.725 pd=5.29 as=27.55 ps=201.02 w=5 l=2
X2 VSS a_512178_643337# a_512178_640243# VSS sky130_fd_pr__nfet_g5v0d10v5 ad=0.725 pd=5.29 as=0.725 ps=5.29 w=5 l=2
X3 VOUT a_515760_641405# VSS VSS sky130_fd_pr__nfet_g5v0d10v5 ad=1.45 pd=10.58 as=0.725 ps=5.29 w=5 l=2
X4 a_509030_644406# a_509030_644406# VDD VDD sky130_fd_pr__pfet_g5v0d10v5 ad=0.725 pd=5.29 as=0.725 ps=5.29 w=5 l=2
X5 VOUT a_515760_641405# VDD VDD sky130_fd_pr__pfet_g5v0d10v5 ad=2.9 pd=20.58 as=1.45 ps=10.29 w=10 l=2
X6 a_512178_640243# a_512178_643337# VSS VSS sky130_fd_pr__nfet_g5v0d10v5 ad=0.725 pd=5.29 as=0.725 ps=5.29 w=5 l=2
X7 a_509030_644406# VINM a_508972_641405# VSS sky130_fd_pr__nfet_g5v0d10v5 ad=0.725 pd=5.29 as=0.725 ps=5.29 w=5 l=2
X8 VSS a_509030_640217# a_509430_640243# VSS sky130_fd_pr__nfet_g5v0d10v5 ad=0.725 pd=5.29 as=0.725 ps=5.29 w=5 l=2
X9 a_509030_640217# VINM a_508972_643337# VDD sky130_fd_pr__pfet_g5v0d10v5 ad=0.725 pd=5.29 as=0.725 ps=5.29 w=5 l=2
X10 a_512178_640243# a_509430_644503# VSS VSS sky130_fd_pr__nfet_g5v0d10v5 ad=0.725 pd=5.29 as=0.725 ps=5.29 w=5 l=2
X11 a_512178_643337# a_512178_643337# VSS VSS sky130_fd_pr__nfet_g5v0d10v5 ad=0.725 pd=5.29 as=0.725 ps=5.29 w=5 l=2
X12 VDD a_512178_641405# a_512178_640243# VDD sky130_fd_pr__pfet_g5v0d10v5 ad=0.725 pd=5.29 as=0.725 ps=5.29 w=5 l=2
X13 a_512178_640243# a_512178_641405# VDD VDD sky130_fd_pr__pfet_g5v0d10v5 ad=0.725 pd=5.29 as=0.725 ps=5.29 w=5 l=2
X14 VSS VSS VSS VSS sky130_fd_pr__nfet_g5v0d10v5 ad=0.725 pd=5.29 as=0 ps=0 w=5 l=2
X15 VDD a_509030_644406# a_509430_644503# VDD sky130_fd_pr__pfet_g5v0d10v5 ad=0.725 pd=5.29 as=0.725 ps=5.29 w=5 l=2
X16 VDD VDD VDD VDD sky130_fd_pr__pfet_g5v0d10v5 ad=0.725 pd=5.29 as=0 ps=0 w=5 l=2
X17 a_512178_640243# a_509430_640243# VDD VDD sky130_fd_pr__pfet_g5v0d10v5 ad=0.725 pd=5.29 as=0.725 ps=5.29 w=5 l=2
X18 VSS VSS a_508972_641405# VSS sky130_fd_pr__nfet_g5v0d10v5 ad=0.725 pd=5.29 as=0.725 ps=5.29 w=5 l=2
X19 VSS a_509430_644503# a_512178_640243# VSS sky130_fd_pr__nfet_g5v0d10v5 ad=0.725 pd=5.29 as=0.725 ps=5.29 w=5 l=2
X20 VSS a_512178_643337# a_512178_643337# VSS sky130_fd_pr__nfet_g5v0d10v5 ad=0.725 pd=5.29 as=0.725 ps=5.29 w=5 l=2
X21 a_512178_641405# a_512178_641405# VDD VDD sky130_fd_pr__pfet_g5v0d10v5 ad=0.725 pd=5.29 as=0.725 ps=5.29 w=5 l=2
X22 VDD VDD a_508972_643337# VDD sky130_fd_pr__pfet_g5v0d10v5 ad=0.725 pd=5.29 as=0.725 ps=5.29 w=5 l=2
X23 a_508972_643337# VDD VDD VDD sky130_fd_pr__pfet_g5v0d10v5 ad=0.725 pd=5.29 as=0.725 ps=5.29 w=5 l=2
X24 a_508972_641405# VSS VSS VSS sky130_fd_pr__nfet_g5v0d10v5 ad=0.725 pd=5.29 as=0.725 ps=5.29 w=5 l=2
X25 a_512178_641405# VINP a_508972_641405# VSS sky130_fd_pr__nfet_g5v0d10v5 ad=0.725 pd=5.29 as=0.725 ps=5.29 w=5 l=2
X26 a_512178_643337# VINP a_508972_643337# VDD sky130_fd_pr__pfet_g5v0d10v5 ad=0.725 pd=5.29 as=0.725 ps=5.29 w=5 l=2
X27 a_512178_641405# VINP a_508972_641405# VSS sky130_fd_pr__nfet_g5v0d10v5 ad=0.725 pd=5.29 as=0.725 ps=5.29 w=5 l=2
X28 a_512178_643337# VINP a_508972_643337# VDD sky130_fd_pr__pfet_g5v0d10v5 ad=0.725 pd=5.29 as=0.725 ps=5.29 w=5 l=2
X29 VSS VSS VSS VSS sky130_fd_pr__nfet_g5v0d10v5 ad=0.725 pd=5.29 as=0 ps=0 w=5 l=2
X30 a_509430_644503# a_509430_644503# VSS VSS sky130_fd_pr__nfet_g5v0d10v5 ad=0.725 pd=5.29 as=0.725 ps=5.29 w=5 l=2
X31 VDD a_509430_640243# a_512178_640243# VDD sky130_fd_pr__pfet_g5v0d10v5 ad=0.725 pd=5.29 as=0.725 ps=5.29 w=5 l=2
X32 VDD a_512178_641405# a_512178_641405# VDD sky130_fd_pr__pfet_g5v0d10v5 ad=0.725 pd=5.29 as=0.725 ps=5.29 w=5 l=2
X33 a_508972_643337# VINP a_512178_643337# VDD sky130_fd_pr__pfet_g5v0d10v5 ad=0.725 pd=5.29 as=0.725 ps=5.29 w=5 l=2
X34 a_508972_641405# VINP a_512178_641405# VSS sky130_fd_pr__nfet_g5v0d10v5 ad=0.725 pd=5.29 as=0.725 ps=5.29 w=5 l=2
X35 a_508972_641405# VINP a_512178_641405# VSS sky130_fd_pr__nfet_g5v0d10v5 ad=0.725 pd=5.29 as=0.725 ps=5.29 w=5 l=2
X36 a_508972_643337# VINP a_512178_643337# VDD sky130_fd_pr__pfet_g5v0d10v5 ad=0.725 pd=5.29 as=0.725 ps=5.29 w=5 l=2
X37 VSS VSS VSS VSS sky130_fd_pr__nfet_g5v0d10v5 ad=1.45 pd=10.58 as=0 ps=0 w=5 l=2
X38 a_509430_640243# a_509030_640217# VSS VSS sky130_fd_pr__nfet_g5v0d10v5 ad=0.725 pd=5.29 as=0.725 ps=5.29 w=5 l=2
X39 VSS a_509030_640217# a_509030_640217# VSS sky130_fd_pr__nfet_g5v0d10v5 ad=0.725 pd=5.29 as=0.725 ps=5.29 w=5 l=2
X40 VSS VSS VSS VSS sky130_fd_pr__nfet_g5v0d10v5 ad=0.725 pd=5.29 as=0 ps=0 w=5 l=2
X41 VDD VDD VDD VDD sky130_fd_pr__pfet_g5v0d10v5 ad=0.725 pd=5.29 as=0 ps=0 w=5 l=2
X42 VSS a_509430_644503# a_509430_644503# VSS sky130_fd_pr__nfet_g5v0d10v5 ad=0.725 pd=5.29 as=0.725 ps=5.29 w=5 l=2
X43 a_509430_640243# a_509430_640243# VDD VDD sky130_fd_pr__pfet_g5v0d10v5 ad=0.725 pd=5.29 as=0.725 ps=5.29 w=5 l=2
X44 a_508972_641405# VBN VSS VSS sky130_fd_pr__nfet_g5v0d10v5 ad=0.725 pd=5.29 as=0.725 ps=5.29 w=5 l=2
X45 a_508972_643337# VBP VDD VDD sky130_fd_pr__pfet_g5v0d10v5 ad=0.725 pd=5.29 as=0.725 ps=5.29 w=5 l=2
X46 a_509030_644406# VINM a_508972_641405# VSS sky130_fd_pr__nfet_g5v0d10v5 ad=0.725 pd=5.29 as=0.725 ps=5.29 w=5 l=2
X47 VSS VSS VSS VSS sky130_fd_pr__nfet_g5v0d10v5 ad=0.725 pd=5.29 as=0 ps=0 w=5 l=2
X48 VSS a_512178_640243# a_515760_641405# VSS sky130_fd_pr__nfet_g5v0d10v5 ad=0.725 pd=5.29 as=1.45 ps=10.58 w=5 l=2
X49 a_509030_640217# VINM a_508972_643337# VDD sky130_fd_pr__pfet_g5v0d10v5 ad=0.725 pd=5.29 as=0.725 ps=5.29 w=5 l=2
X50 VDD a_512178_640243# a_515760_641405# VDD sky130_fd_pr__pfet_g5v0d10v5 ad=1.45 pd=10.29 as=2.9 ps=20.58 w=10 l=2
X51 VDD VDD VDD VDD sky130_fd_pr__pfet_g5v0d10v5 ad=1.45 pd=10.58 as=0 ps=0 w=5 l=2
X52 a_509430_644503# a_509030_644406# VDD VDD sky130_fd_pr__pfet_g5v0d10v5 ad=0.725 pd=5.29 as=0.725 ps=5.29 w=5 l=2
X53 VDD a_509030_644406# a_509030_644406# VDD sky130_fd_pr__pfet_g5v0d10v5 ad=0.725 pd=5.29 as=0.725 ps=5.29 w=5 l=2
X54 VDD VDD VDD VDD sky130_fd_pr__pfet_g5v0d10v5 ad=0.725 pd=5.29 as=0 ps=0 w=5 l=2
X55 VDD a_509430_640243# a_509430_640243# VDD sky130_fd_pr__pfet_g5v0d10v5 ad=0.725 pd=5.29 as=0.725 ps=5.29 w=5 l=2
X56 VDD VDD VDD VDD sky130_fd_pr__pfet_g5v0d10v5 ad=1.45 pd=10.58 as=0 ps=0 w=5 l=2
X57 VDD VDD VDD VDD sky130_fd_pr__pfet_g5v0d10v5 ad=0.725 pd=5.29 as=0 ps=0 w=5 l=2
X58 VSS VSS VSS VSS sky130_fd_pr__nfet_g5v0d10v5 ad=1.45 pd=10.58 as=0 ps=0 w=5 l=2
X59 VSS VBN a_508972_641405# VSS sky130_fd_pr__nfet_g5v0d10v5 ad=0.725 pd=5.29 as=0.725 ps=5.29 w=5 l=2
X60 VSS VSS VSS VSS sky130_fd_pr__nfet_g5v0d10v5 ad=0.725 pd=5.29 as=0 ps=0 w=5 l=2
X61 a_509030_640217# a_509030_640217# VSS VSS sky130_fd_pr__nfet_g5v0d10v5 ad=0.725 pd=5.29 as=0.725 ps=5.29 w=5 l=2
X62 VDD VBP a_508972_643337# VDD sky130_fd_pr__pfet_g5v0d10v5 ad=0.725 pd=5.29 as=0.725 ps=5.29 w=5 l=2
X63 a_508972_643337# VINM a_509030_640217# VDD sky130_fd_pr__pfet_g5v0d10v5 ad=0.725 pd=5.29 as=0.725 ps=5.29 w=5 l=2
X64 a_508972_641405# VINM a_509030_644406# VSS sky130_fd_pr__nfet_g5v0d10v5 ad=0.725 pd=5.29 as=0.725 ps=5.29 w=5 l=2
X65 a_508972_641405# VINM a_509030_644406# VSS sky130_fd_pr__nfet_g5v0d10v5 ad=0.725 pd=5.29 as=0.725 ps=5.29 w=5 l=2
X66 VDD VDD VDD VDD sky130_fd_pr__pfet_g5v0d10v5 ad=0.725 pd=5.29 as=0 ps=0 w=5 l=2
X67 a_508972_643337# VINM a_509030_640217# VDD sky130_fd_pr__pfet_g5v0d10v5 ad=0.725 pd=5.29 as=0.725 ps=5.29 w=5 l=2
C0 a_509030_644406# a_509430_644503# 0.90083f
C1 a_508972_641405# a_509030_640217# 0.42611f
C2 VINM a_509030_640217# 2.59066f
C3 VINP VDD 3.21933f
C4 VBP a_509430_640243# 0.06438f
C5 VDD a_509030_644406# 4.86287f
C6 VINP a_512178_640243# 0.35949f
C7 a_512178_643337# a_509030_640217# 0.01053f
C8 VINP VBP 0.34859f
C9 a_509430_644503# a_509030_640217# 1.23391f
C10 VBP a_509030_644406# 0.27268f
C11 VBN a_508972_643337# 0.19129f
C12 VINM a_508972_641405# 1.41434f
C13 VDD a_509030_640217# 2.37322f
C14 a_512178_643337# a_508972_641405# 0.31313f
C15 VINM a_512178_643337# 0.01421f
C16 a_509430_644503# a_508972_641405# 0.5584f
C17 VBP a_509030_640217# 0.00102f
C18 VINM a_509430_644503# 0.96096f
C19 a_509430_644503# a_512178_643337# 0.12042f
C20 VDD a_508972_641405# 0.50515f
C21 VDD VINM 3.09373f
C22 a_512178_640243# a_508972_641405# 0.27987f
C23 VDD a_512178_643337# 0.13276f
C24 a_512178_640243# a_512178_643337# 1.7952f
C25 VBP VINM 0.01305f
C26 VDD a_509430_644503# 3.5568f
C27 a_509430_640243# a_512178_641405# 0.35413f
C28 a_512178_640243# a_509430_644503# 0.6428f
C29 a_509430_640243# a_508972_643337# 0.39694f
C30 VINP a_512178_641405# 2.69762f
C31 VBP a_509430_644503# 0
C32 VDD a_512178_640243# 4.92844f
C33 a_509030_644406# a_512178_641405# 0.26301f
C34 VINP a_508972_643337# 1.45282f
C35 VDD VBP 5.61405f
C36 a_509030_644406# a_508972_643337# 0.51163f
C37 VBN a_509430_640243# 0.98978f
C38 a_509030_640217# a_512178_641405# 0
C39 VINP VBN 0.08997f
C40 a_508972_643337# a_509030_640217# 1.14747f
C41 VDD a_515760_641405# 3.28085f
C42 a_509030_644406# VBN 0.17979f
C43 a_512178_640243# a_515760_641405# 1.25241f
C44 a_508972_641405# a_512178_641405# 1.15266f
C45 VINM a_512178_641405# 0.12651f
C46 a_512178_643337# a_512178_641405# 0.49035f
C47 a_508972_641405# a_508972_643337# 0.0062f
C48 VBN a_509030_640217# 0.26153f
C49 VINM a_508972_643337# 1.36907f
C50 VDD VOUT 1.53185f
C51 a_509430_644503# a_512178_641405# 0.0261f
C52 a_512178_640243# VOUT 0.17898f
C53 a_512178_643337# a_508972_643337# 1.14751f
C54 VDD a_512178_641405# 4.10192f
C55 a_509430_644503# a_508972_643337# 0.29818f
C56 a_512178_640243# a_512178_641405# 1.78394f
C57 a_508972_641405# VBN 0.60807f
C58 VINM VBN 0.45619f
C59 VDD a_508972_643337# 2.36901f
C60 VINP a_509430_640243# 0.64809f
C61 a_512178_640243# a_508972_643337# 0.23111f
C62 a_509030_644406# a_509430_640243# 1.26296f
C63 VBP a_508972_643337# 0.60602f
C64 a_509430_644503# VBN 0.00285f
C65 a_515760_641405# VOUT 1.48099f
C66 VINP a_509030_644406# 0.2678f
C67 VDD VBN 2.92103f
C68 a_515760_641405# a_512178_641405# 0.00101f
C69 a_509430_640243# a_509030_640217# 0.70228f
C70 VBP VBN 0.79611f
C71 VINP a_509030_640217# 0.18009f
C72 a_509030_644406# a_509030_640217# 0.4774f
C73 a_508972_641405# a_509430_640243# 0.18425f
C74 VINM a_509430_640243# 0.65296f
C75 a_512178_643337# a_509430_640243# 0.02172f
C76 VINP a_508972_641405# 1.40587f
C77 VINP VINM 1.35005f
C78 a_509030_644406# a_508972_641405# 1.15266f
C79 a_509030_644406# VINM 2.58336f
C80 a_509430_644503# a_509430_640243# 0.98339f
C81 VINP a_512178_643337# 2.51984f
C82 a_508972_643337# a_512178_641405# 0.41663f
C83 a_509030_644406# a_512178_643337# 0
C84 VDD a_509430_640243# 6.92385f
C85 VINP a_509430_644503# 0.62484f
C86 a_512178_640243# a_509430_640243# 0.61221f
C87 a_508972_641405# VSS 3.25133f
C88 VBN VSS 3.42714f
C89 VOUT VSS 2.35669f
C90 a_515760_641405# VSS 3.44841f
C91 a_512178_643337# VSS 8.67729f
C92 a_509030_640217# VSS 5.48832f
C93 a_508972_643337# VSS 1.33189f
C94 VINP VSS 6.3403f
C95 VINM VSS 4.98551f
C96 VBP VSS 1.09384f
C97 a_512178_640243# VSS 12.4679f
C98 a_509430_644503# VSS 5.95612f
C99 a_512178_641405# VSS 4.0691f
C100 a_509430_640243# VSS 2.96475f
C101 a_509030_644406# VSS 1.99232f
C102 VDD VSS 87.0523f
.ends

.subckt EF_R2RVC VINP VINM DVDD VOUT comparator_bias_0/a_508013_648897# DVSS VSS VDD
Xsky130_fd_sc_hvl__lsbufhv2lv_1_0 comparator_0/VOUT DVDD DVSS DVSS VDD VDD VOUT sky130_fd_sc_hvl__lsbufhv2lv_1_0/a_389_141#
+ sky130_fd_sc_hvl__lsbufhv2lv_1_0/a_30_1337# sky130_fd_sc_hvl__lsbufhv2lv_1_0/a_30_207#
+ sky130_fd_sc_hvl__lsbufhv2lv_1_0/a_389_1337# arm_r2rvc_lsbufhv2lv
Xcomparator_bias_0 comparator_bias_0/a_512471_648367# comparator_bias_0/a_508011_647837#
+ comparator_bias_0/a_508013_648897# comparator_0/VBP comparator_0/VBN comparator_bias_0/a_508011_646777#
+ comparator_bias_0/a_508011_646247# comparator_bias_0/a_512471_647307# comparator_bias_0/a_512471_646247#
+ VDD VSS comparator_bias_0/a_513709_648116# comparator_bias
Xcomparator_0 comparator_0/a_509430_640243# comparator_0/a_512178_643337# comparator_0/a_509430_644503#
+ comparator_0/a_508972_641405# comparator_0/VBP comparator_0/a_512178_641405# comparator_0/VBN
+ VINP comparator_0/a_509030_644406# comparator_0/a_509030_640217# VINM comparator_0/a_515760_641405#
+ VDD VSS comparator_0/VOUT comparator_0/a_512178_640243# comparator_0/a_508972_643337#
+ comparator
C0 comparator_0/a_508972_641405# VDD 0.00125f
C1 DVDD sky130_fd_sc_hvl__lsbufhv2lv_1_0/a_389_1337# 0.00538f
C2 comparator_0/a_509430_640243# VINM 0
C3 VDD VOUT 0.28401f
C4 comparator_0/a_515760_641405# sky130_fd_sc_hvl__lsbufhv2lv_1_0/a_30_207# 0.00186f
C5 comparator_0/VBP VINP 0.03618f
C6 comparator_0/VOUT sky130_fd_sc_hvl__lsbufhv2lv_1_0/a_30_207# 0.03677f
C7 comparator_0/a_509030_644406# comparator_0/VBP 0.00102f
C8 VDD sky130_fd_sc_hvl__lsbufhv2lv_1_0/a_30_1337# -0.00574f
C9 VDD VINP 0.38956f
C10 comparator_bias_0/a_508011_646247# comparator_0/a_512178_640243# 0
C11 comparator_0/a_509030_644406# VDD 0.0829f
C12 sky130_fd_sc_hvl__lsbufhv2lv_1_0/a_389_141# DVDD -0.00296f
C13 comparator_0/a_512178_640243# VDD 0.14053f
C14 VDD comparator_bias_0/a_512471_648367# 0
C15 comparator_bias_0/a_508011_646777# VDD 0.11962f
C16 comparator_0/VBP VDD 0.68418f
C17 comparator_0/VBN VINP 0
C18 comparator_0/a_509030_644406# comparator_0/VBN 0.03082f
C19 comparator_bias_0/a_508011_646247# VDD 1.36744f
C20 comparator_0/VBP comparator_0/VBN 0.09092f
C21 comparator_0/a_508972_643337# VDD 0.00226f
C22 comparator_0/a_515760_641405# VOUT 0
C23 comparator_0/VOUT VOUT 0.04594f
C24 VDD comparator_0/VBN 1.47005f
C25 comparator_0/a_515760_641405# sky130_fd_sc_hvl__lsbufhv2lv_1_0/a_30_1337# 0
C26 comparator_0/VOUT sky130_fd_sc_hvl__lsbufhv2lv_1_0/a_30_1337# 0.03964f
C27 comparator_0/a_512178_640243# comparator_0/a_515760_641405# -0
C28 comparator_0/a_512178_640243# comparator_0/VOUT 0
C29 comparator_bias_0/a_508011_646247# comparator_0/a_515760_641405# 0
C30 comparator_bias_0/a_508011_646247# comparator_0/VOUT 0
C31 comparator_0/a_515760_641405# VDD 0.13094f
C32 comparator_0/a_509430_644503# VDD 0.176f
C33 DVDD sky130_fd_sc_hvl__lsbufhv2lv_1_0/a_30_207# -0
C34 comparator_0/VOUT VDD 1.14114f
C35 comparator_0/a_509030_644406# comparator_bias_0/a_513709_648116# 0.00102f
C36 comparator_0/a_509030_640217# VDD 0.17261f
C37 comparator_0/a_509430_644503# comparator_0/VBN 0.00198f
C38 sky130_fd_sc_hvl__lsbufhv2lv_1_0/a_389_1337# VOUT 0.07651f
C39 VINP VINM 0.73665f
C40 comparator_bias_0/a_513709_648116# VDD 0.03806f
C41 comparator_0/a_512178_643337# VDD 0.17143f
C42 comparator_0/VBP VINM 0.00196f
C43 comparator_bias_0/a_512471_646247# comparator_0/a_512178_641405# 0.00974f
C44 VDD comparator_bias_0/a_508011_647837# 0.11516f
C45 VDD VINM 0.34491f
C46 DVDD VOUT 0.37102f
C47 comparator_0/VBN VINM 0.04067f
C48 sky130_fd_sc_hvl__lsbufhv2lv_1_0/a_389_141# VOUT 0.04889f
C49 DVDD sky130_fd_sc_hvl__lsbufhv2lv_1_0/a_30_1337# 0
C50 VDD sky130_fd_sc_hvl__lsbufhv2lv_1_0/a_389_1337# 0.00347f
C51 comparator_0/a_509430_640243# VINP 0
C52 DVDD VDD 1.26191f
C53 sky130_fd_sc_hvl__lsbufhv2lv_1_0/a_389_141# VDD 0.00643f
C54 comparator_0/a_509430_640243# VDD 0.23812f
C55 comparator_0/VOUT sky130_fd_sc_hvl__lsbufhv2lv_1_0/a_389_1337# 0.00267f
C56 comparator_bias_0/a_508011_646247# comparator_0/a_512178_641405# 0.00298f
C57 comparator_0/a_509430_640243# comparator_0/VBN 0.00675f
C58 sky130_fd_sc_hvl__lsbufhv2lv_1_0/a_30_207# VOUT 0.01278f
C59 VDD comparator_0/a_512178_641405# 0.31189f
C60 comparator_bias_0/a_508013_648897# VDD 0.20052f
C61 comparator_0/VOUT DVDD 0.04637f
C62 comparator_0/a_515760_641405# sky130_fd_sc_hvl__lsbufhv2lv_1_0/a_389_141# 0
C63 comparator_0/a_512178_640243# comparator_bias_0/a_512471_646247# 0
C64 comparator_0/VOUT sky130_fd_sc_hvl__lsbufhv2lv_1_0/a_389_141# 0.01459f
C65 VDD comparator_bias_0/a_512471_646247# 0.05789f
C66 VDD sky130_fd_sc_hvl__lsbufhv2lv_1_0/a_30_207# 0.00566f
C67 sky130_fd_sc_hvl__lsbufhv2lv_1_0/a_30_1337# VOUT 0.01739f
C68 comparator_bias_0/a_513709_648116# comparator_0/a_509430_640243# 0
C69 comparator_0/a_508972_641405# VSS 3.38586f
C70 comparator_0/VOUT VSS 2.92358f
C71 comparator_0/a_515760_641405# VSS 4.06891f
C72 comparator_0/a_512178_643337# VSS 9.89851f
C73 comparator_0/a_509030_640217# VSS 6.69385f
C74 comparator_0/a_508972_643337# VSS 1.3408f
C75 VINP VSS 8.34951f
C76 VINM VSS 6.99398f
C77 comparator_0/a_512178_640243# VSS 13.40512f
C78 comparator_0/a_509430_644503# VSS 7.16893f
C79 comparator_0/a_512178_641405# VSS 4.18601f
C80 comparator_0/a_509430_640243# VSS 3.2062f
C81 comparator_0/a_509030_644406# VSS 2.18597f
C82 comparator_bias_0/a_512471_646247# VSS 0.79029f
C83 comparator_bias_0/a_508011_646777# VSS 0.83516f
C84 comparator_0/VBP VSS 4.08831f
C85 comparator_bias_0/a_513709_648116# VSS 4.21726f
C86 comparator_bias_0/a_508011_646247# VSS 6.11657f
C87 comparator_0/VBN VSS 18.01621f
C88 comparator_bias_0/a_512471_647307# VSS 0.72558f
C89 comparator_bias_0/a_508011_647837# VSS 0.84494f
C90 comparator_bias_0/a_512471_648367# VSS 0.74092f
C91 comparator_bias_0/a_508013_648897# VSS 0.94796f
C92 VOUT VSS 1.35271f
C93 DVDD VSS 1.77717f
C94 VDD VSS 0.4324p
C95 sky130_fd_sc_hvl__lsbufhv2lv_1_0/a_30_207# VSS 0.67159f
C96 sky130_fd_sc_hvl__lsbufhv2lv_1_0/a_389_141# VSS 0.77503f
C97 sky130_fd_sc_hvl__lsbufhv2lv_1_0/a_389_1337# VSS 0.68219f
C98 sky130_fd_sc_hvl__lsbufhv2lv_1_0/a_30_1337# VSS 1.10935f
.ends

.subckt tt_um_armohamed_r2rvc clk ena rst_n ua[0] ua[1] ua[2] ua[3] ua[4] ua[5] ua[6]
+ ua[7] ui_in[0] ui_in[1] ui_in[2] ui_in[3] ui_in[4] ui_in[5] ui_in[6] ui_in[7] uio_in[0]
+ uio_in[1] uio_in[2] uio_in[3] uio_in[4] uio_in[5] uio_in[6] uio_in[7] uio_oe[0]
+ uio_oe[1] uio_oe[2] uio_oe[3] uio_oe[4] uio_oe[5] uio_oe[6] uio_oe[7] uio_out[0]
+ uio_out[1] uio_out[2] uio_out[3] uio_out[4] uio_out[5] uio_out[6] uio_out[7] uo_out[0]
+ uo_out[1] uo_out[2] uo_out[3] uo_out[4] uo_out[5] uo_out[6] uo_out[7] VDPWR VGND
+ VAPWR
XEF_R2RVC_0 ua[0] ua[1] VDPWR uo_out[0] EF_R2RVC_0/comparator_bias_0/a_508013_648897#
+ VGND VGND VAPWR EF_R2RVC
R0 VGND uio_oe[7] 0.000000
R1 VGND uo_out[3] 0.000000
R2 VGND uio_oe[6] 0.000000
R3 VGND uo_out[2] 0.000000
R4 VGND uio_oe[5] 0.000000
R5 VGND uo_out[1] 0.000000
R6 VGND uio_oe[4] 0.000000
R7 VGND uio_out[7] 0.000000
R8 VGND uio_oe[3] 0.000000
R9 VGND uio_out[6] 0.000000
R10 VGND uio_oe[1] 0.000000
R11 VGND uio_oe[2] 0.000000
R12 VGND uio_out[4] 0.000000
R13 VGND uio_out[5] 0.000000
R14 VGND uio_out[3] 0.000000
R15 VGND uo_out[7] 0.000000
R16 VGND uo_out[6] 0.000000
R17 VGND uio_oe[0] 0.000000
R18 VGND uio_out[2] 0.000000
R19 VGND uio_out[1] 0.000000
R20 VGND uo_out[5] 0.000000
R21 VGND uio_out[0] 0.000000
R22 VGND uo_out[4] 0.000000
C0 VAPWR ua[1] 0.00395f
C1 uio_in[4] uio_in[3] 0.03102f
C2 uio_in[4] uio_in[5] 0.03102f
C3 uio_in[6] uio_in[5] 0.03102f
C4 uio_in[7] uio_in[6] 0.03102f
C5 uo_out[0] VDPWR 0.30813f
C6 ua[7] VDPWR 0.01707f
C7 VAPWR ua[0] 0.00399f
C8 ua[1] ua[0] 3.81315f
C9 VAPWR VDPWR 0.46258f
C10 ena clk 0.03102f
C11 clk rst_n 0.03102f
C12 ui_in[0] rst_n 0.03102f
C13 ui_in[0] ui_in[1] 0.03102f
C14 ui_in[1] ui_in[2] 0.03102f
C15 ui_in[2] ui_in[3] 0.03102f
C16 ui_in[4] ui_in[3] 0.03102f
C17 ui_in[4] ui_in[5] 0.03102f
C18 uio_in[7] uo_out[0] 0.03102f
C19 ui_in[6] ui_in[5] 0.03102f
C20 ui_in[7] ui_in[6] 0.03102f
C21 ui_in[7] uio_in[0] 0.03102f
C22 uio_in[1] uio_in[0] 0.03102f
C23 uio_in[2] uio_in[1] 0.03102f
C24 uio_in[2] uio_in[3] 0.03102f
C25 ua[2] VGND 0.14696f
C26 ua[3] VGND 0.14696f
C27 ua[4] VGND 0.14696f
C28 ua[5] VGND 0.14696f
C29 ua[6] VGND 0.14696f
C30 ua[7] VGND 0.12801f
C31 ena VGND 0.07038f
C32 clk VGND 0.04288f
C33 rst_n VGND 0.04288f
C34 ui_in[0] VGND 0.04288f
C35 ui_in[1] VGND 0.04288f
C36 ui_in[2] VGND 0.04288f
C37 ui_in[3] VGND 0.04288f
C38 ui_in[4] VGND 0.04288f
C39 ui_in[5] VGND 0.04288f
C40 ui_in[6] VGND 0.04288f
C41 ui_in[7] VGND 0.04288f
C42 uio_in[0] VGND 0.04288f
C43 uio_in[1] VGND 0.04288f
C44 uio_in[2] VGND 0.04288f
C45 uio_in[3] VGND 0.04288f
C46 uio_in[4] VGND 0.04288f
C47 uio_in[5] VGND 0.04288f
C48 uio_in[6] VGND 0.04288f
C49 uio_in[7] VGND 0.04288f
C50 EF_R2RVC_0/comparator_0/a_508972_641405# VGND 3.25133f
C51 EF_R2RVC_0/comparator_0/VOUT VGND 2.24988f
C52 EF_R2RVC_0/comparator_0/a_515760_641405# VGND 3.44841f
C53 EF_R2RVC_0/comparator_0/a_512178_643337# VGND 8.67729f
C54 EF_R2RVC_0/comparator_0/a_509030_640217# VGND 5.48832f
C55 EF_R2RVC_0/comparator_0/a_508972_643337# VGND 1.33189f
C56 ua[0] VGND 20.61954f
C57 ua[1] VGND 18.39352f
C58 EF_R2RVC_0/comparator_0/a_512178_640243# VGND 12.4679f
C59 EF_R2RVC_0/comparator_0/a_509430_644503# VGND 5.95612f
C60 EF_R2RVC_0/comparator_0/a_512178_641405# VGND 4.0691f
C61 EF_R2RVC_0/comparator_0/a_509430_640243# VGND 2.96475f
C62 EF_R2RVC_0/comparator_0/a_509030_644406# VGND 1.99232f
C63 EF_R2RVC_0/comparator_bias_0/a_512471_646247# VGND 0.76689f
C64 EF_R2RVC_0/comparator_bias_0/a_508011_646777# VGND 0.83516f
C65 EF_R2RVC_0/comparator_0/VBP VGND 3.74641f
C66 EF_R2RVC_0/comparator_bias_0/a_513709_648116# VGND 3.86727f
C67 EF_R2RVC_0/comparator_bias_0/a_508011_646247# VGND 5.38609f
C68 EF_R2RVC_0/comparator_0/VBN VGND 15.56673f
C69 EF_R2RVC_0/comparator_bias_0/a_512471_647307# VGND 0.72428f
C70 EF_R2RVC_0/comparator_bias_0/a_508011_647837# VGND 0.83555f
C71 EF_R2RVC_0/comparator_bias_0/a_512471_648367# VGND 0.71741f
C72 EF_R2RVC_0/comparator_bias_0/a_508013_648897# VGND 0.88419f
C73 uo_out[0] VGND 14.66931f
C74 VDPWR VGND 44.80826f
C75 VAPWR VGND 0.32023p
C76 EF_R2RVC_0/sky130_fd_sc_hvl__lsbufhv2lv_1_0/a_30_207# VGND 0.66569f
C77 EF_R2RVC_0/sky130_fd_sc_hvl__lsbufhv2lv_1_0/a_389_141# VGND 0.77447f
C78 EF_R2RVC_0/sky130_fd_sc_hvl__lsbufhv2lv_1_0/a_389_1337# VGND 0.55786f
C79 EF_R2RVC_0/sky130_fd_sc_hvl__lsbufhv2lv_1_0/a_30_1337# VGND 1.03826f
.ends
