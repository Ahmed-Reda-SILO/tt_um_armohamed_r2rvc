* TOPOLOGY CHECK ONLY: C removed and distributed route R shorted.
.subckt tt_um_armohamed_r2rvc_rc clk ena rst_n ua[0] ua[1] ua[2] ua[3] ua[4] ua[5] ua[6] ua[7] ui_in[0] ui_in[1] ui_in[2] ui_in[3] ui_in[4] ui_in[5] ui_in[6] ui_in[7] uio_in[0] uio_in[1] uio_in[2] uio_in[3] uio_in[4] uio_in[5] uio_in[6] uio_in[7] uio_oe[0] uio_oe[1] uio_oe[2] uio_oe[3] uio_oe[4] uio_oe[5] uio_oe[6] uio_oe[7] uio_out[0] uio_out[1] uio_out[2] uio_out[3] uio_out[4] uio_out[5] uio_out[6] uio_out[7] uo_out[0] uo_out[1] uo_out[2] uo_out[3] uo_out[4] uo_out[5] uo_out[6] uo_out[7] VDPWR VGND VAPWR
RTIE2 uio_oe[0] VGND 0
RTIE3 uio_oe[1] VGND 0
RTIE4 uio_oe[2] VGND 0
RTIE5 uio_oe[3] VGND 0
RTIE6 uio_oe[4] VGND 0
RTIE7 uio_oe[5] VGND 0
RTIE8 uio_oe[6] VGND 0
RTIE9 uio_oe[7] VGND 0
RTIE10 uio_out[0] VGND 0
RTIE11 uio_out[1] VGND 0
RTIE12 uio_out[2] VGND 0
RTIE13 uio_out[3] VGND 0
RTIE14 uio_out[4] VGND 0
RTIE15 uio_out[5] VGND 0
RTIE16 uio_out[6] VGND 0
RTIE17 uio_out[7] VGND 0
RTIE18 uo_out[1] VGND 0
RTIE19 uo_out[2] VGND 0
RTIE20 uo_out[3] VGND 0
RTIE21 uo_out[4] VGND 0
RTIE22 uo_out[5] VGND 0
RTIE23 uo_out[6] VGND 0
RTIE24 uo_out[7] VGND 0
X0 a_9097_16782.t0 ua[1] a_9155_19783.t0 VGND sky130_fd_pr__nfet_g5v0d10v5 ad=0.725 pd=5.29 as=0.725 ps=5.29 w=5 l=2
X1 a_9155_19783.t0 ua[1] a_9097_16782.t0 VGND sky130_fd_pr__nfet_g5v0d10v5 ad=0.725 pd=5.29 as=0.725 ps=5.29 w=5 l=2
X2 a_9097_18714.n43 ua[1] a_9155_15594.n82 VAPWR sky130_fd_pr__pfet_g5v0d10v5 ad=0.725 pd=5.29 as=0.725 ps=5.29 w=5 l=2
X3 VAPWR VAPWR VAPWR VAPWR sky130_fd_pr__pfet_g5v0d10v5 ad=1.45 pd=10.58 as=0 ps=0 w=5 l=2
X4 a_12303_15620.n11 a_9555_15620.n77 VAPWR VAPWR sky130_fd_pr__pfet_g5v0d10v5 ad=0.725 pd=5.29 as=0.725 ps=5.29 w=5 l=2
X5 a_16801_16782.n62 a_15885_16782.n80 VGND VGND sky130_fd_pr__nfet_g5v0d10v5 ad=1.45 pd=10.58 as=0.725 ps=5.29 w=5 l=2
X6 VGND a_12303_15620.n11 a_15885_16782.n80 VGND sky130_fd_pr__nfet_g5v0d10v5 ad=0.725 pd=5.29 as=1.45 ps=10.58 w=5 l=2
X7 VGND a_18115_18320.t0 a_18355_19224.t0 VGND sky130_fd_pr__nfet_g5v0d10v5 ad=0.105 pd=1.03 as=0.105 ps=1.03 w=0.75 l=0.5
X8 VGND a_18049_18522.t0 a_18059_19108.t0 VGND sky130_fd_pr__nfet_g5v0d10v5 ad=0.19875 pd=2.03 as=0.105 ps=1.03 w=0.75 l=0.5
X9 a_12303_16782.t0 a_12303_16782.t0 VAPWR VAPWR sky130_fd_pr__pfet_g5v0d10v5 ad=0.725 pd=5.29 as=0.725 ps=5.29 w=5 l=2
X10 VGND a_18049_18522.t0 a_18059_19108.t0 VGND sky130_fd_pr__nfet_g5v0d10v5 ad=0.19875 pd=2.03 as=0.19875 ps=2.03 w=0.75 l=0.5
X11 VGND a_8697_16756.n174 a_8249_23526.n69 VGND sky130_fd_pr__nfet_g5v0d10v5 ad=0.725 pd=5.29 as=0.725 ps=5.29 w=5 l=2
X12 a_8697_16756.n174 a_8697_16756.n174 VGND VGND sky130_fd_pr__nfet_g5v0d10v5 ad=0.725 pd=5.29 as=0.725 ps=5.29 w=5 l=2
X13 VGND VGND a_8697_16756.n174 VGND sky130_fd_pr__nfet_g5v0d10v5 ad=1.45 pd=10.58 as=0.725 ps=5.29 w=5 l=2
X14 VGND a_12303_18714.n82 a_12303_15620.n11 VGND sky130_fd_pr__nfet_g5v0d10v5 ad=0.725 pd=5.29 as=0.725 ps=5.29 w=5 l=2
X15 VGND VGND VGND VGND sky130_fd_pr__nfet_g5v0d10v5 ad=1.45 pd=10.58 as=0 ps=0 w=5 l=2
X16 a_12303_16782.t0 ua[0] a_9097_16782.t0 VGND sky130_fd_pr__nfet_g5v0d10v5 ad=0.725 pd=5.29 as=0.725 ps=5.29 w=5 l=2
X17 a_12303_16782.t0 ua[0] a_9097_16782.t0 VGND sky130_fd_pr__nfet_g5v0d10v5 ad=0.725 pd=5.29 as=0.725 ps=5.29 w=5 l=2
X18 VAPWR a_9155_19783.t0 a_9155_19783.t0 VAPWR sky130_fd_pr__pfet_g5v0d10v5 ad=0.725 pd=5.29 as=0.725 ps=5.29 w=5 l=2
X19 VGND VGND VGND VGND sky130_fd_pr__nfet_g5v0d10v5 ad=0.725 pd=5.29 as=0 ps=0 w=5 l=2
X20 a_9097_16782.t0 ua[1] a_9155_19783.t0 VGND sky130_fd_pr__nfet_g5v0d10v5 ad=0.725 pd=5.29 as=0.725 ps=5.29 w=5 l=2
X21 a_13355_22717.t0 a_17815_22187.t0 VAPWR sky130_fd_pr__res_high_po_1p41 l=20.3
X22 a_13353_24307.t0 a_17813_24307.t0 VAPWR sky130_fd_pr__res_high_po_1p41 l=20.3
X23 VGND a_9555_19880.n75 a_12303_15620.n11 VGND sky130_fd_pr__nfet_g5v0d10v5 ad=0.725 pd=5.29 as=0.725 ps=5.29 w=5 l=2
X24 a_8825_23526.t0 a_8697_16756.n174 a_8697_16756.n174 VAPWR sky130_fd_pr__pfet_g5v0d10v5 ad=0.29 pd=2.58 as=0.29 ps=2.58 w=1 l=15
X25 a_18355_19224.t0 a_18115_18320.t0 VGND VGND sky130_fd_pr__nfet_g5v0d10v5 ad=0.49875 pd=2.83 as=0.105 ps=1.03 w=0.75 l=0.5
X26 VGND a_8697_16756.n174 a_9225_23623.n35 VGND sky130_fd_pr__nfet_g5v0d10v5 ad=0.725 pd=5.29 as=0.725 ps=5.29 w=5 l=2
X27 VGND a_12303_18714.n82 a_12303_18714.n82 VGND sky130_fd_pr__nfet_g5v0d10v5 ad=0.725 pd=5.29 as=0.725 ps=5.29 w=5 l=2
X28 a_13355_21657.t0 a_8825_23526.t0 VAPWR sky130_fd_pr__res_high_po_1p41 l=20.3
X29 a_13353_24307.t0 a_17815_23247.t0 VAPWR sky130_fd_pr__res_high_po_1p41 l=20.3
X30 a_9155_15594.n82 a_9155_15594.n82 VGND VGND sky130_fd_pr__nfet_g5v0d10v5 ad=0.725 pd=5.29 as=0.725 ps=5.29 w=5 l=2
X31 VAPWR VAPWR VAPWR VAPWR sky130_fd_pr__pfet_g5v0d10v5 ad=0.725 pd=5.29 as=0 ps=0 w=5 l=2
X32 a_9555_15620.n77 a_9155_15594.n82 VGND VGND sky130_fd_pr__nfet_g5v0d10v5 ad=0.725 pd=5.29 as=0.725 ps=5.29 w=5 l=2
X33 VGND VGND VGND VGND sky130_fd_pr__nfet_g5v0d10v5 ad=0.725 pd=5.29 as=0 ps=0 w=5 l=2
X34 a_12303_15620.n11 a_12303_18714.n82 VGND VGND sky130_fd_pr__nfet_g5v0d10v5 ad=0.725 pd=5.29 as=0.725 ps=5.29 w=5 l=2
X35 VAPWR a_8825_23526.t0 a_9225_23623.n35 VAPWR sky130_fd_pr__pfet_g5v0d10v5 ad=0.725 pd=5.29 as=0.725 ps=5.29 w=5 l=2
X36 VGND VGND VGND VGND sky130_fd_pr__nfet_g5v0d10v5 ad=0.725 pd=5.29 as=0 ps=0 w=5 l=2
X37 VGND a_18115_18320.t0 a_18355_19224.t0 VGND sky130_fd_pr__nfet_g5v0d10v5 ad=0.19875 pd=2.03 as=0.19875 ps=2.03 w=0.75 l=0.5
X38 VAPWR VAPWR VAPWR VAPWR sky130_fd_pr__pfet_g5v0d10v5 ad=0.725 pd=5.29 as=0 ps=0 w=5 l=2
X39 VGND a_9155_15594.n82 a_9555_15620.n77 VGND sky130_fd_pr__nfet_g5v0d10v5 ad=0.725 pd=5.29 as=0.725 ps=5.29 w=5 l=2
X40 VGND a_9555_19880.n75 a_9555_19880.n75 VGND sky130_fd_pr__nfet_g5v0d10v5 ad=0.725 pd=5.29 as=0.725 ps=5.29 w=5 l=2
X41 a_9555_19880.n75 a_9555_19880.n75 VGND VGND sky130_fd_pr__nfet_g5v0d10v5 ad=0.725 pd=5.29 as=0.725 ps=5.29 w=5 l=2
X42 VAPWR a_12303_16782.t0 a_12303_15620.n11 VAPWR sky130_fd_pr__pfet_g5v0d10v5 ad=0.725 pd=5.29 as=0.725 ps=5.29 w=5 l=2
X43 VGND a_18059_19108.t0 uo_out[0] VGND sky130_fd_pr__nfet_01v8 ad=0.1961 pd=2.01 as=0.1961 ps=2.01 w=0.74 l=0.15
X44 a_9097_18714.n43 ua[0] a_12303_18714.n82 VAPWR sky130_fd_pr__pfet_g5v0d10v5 ad=0.725 pd=5.29 as=0.725 ps=5.29 w=5 l=2
X45 a_9225_23623.n35 a_8825_23526.t0 VAPWR VAPWR sky130_fd_pr__pfet_g5v0d10v5 ad=0.725 pd=5.29 as=0.725 ps=5.29 w=5 l=2
X46 VDPWR a_18355_19224.t0 a_18059_19108.t0 VDPWR sky130_fd_pr__pfet_01v8_hvt ad=0.2968 pd=2.77 as=0.2968 ps=2.77 w=1.12 l=0.15
X47 VGND VGND VGND VGND sky130_fd_pr__nfet_g5v0d10v5 ad=0.725 pd=5.29 as=0 ps=0 w=5 l=2
X48 a_9097_18714.n43 ua[0] a_12303_18714.n82 VAPWR sky130_fd_pr__pfet_g5v0d10v5 ad=0.725 pd=5.29 as=0.725 ps=5.29 w=5 l=2
X49 a_8697_16756.n174 a_9225_23623.n35 a_8825_23526.t0 VAPWR sky130_fd_pr__pfet_g5v0d10v5 ad=0.725 pd=5.29 as=0.725 ps=5.29 w=5 l=2
X50 VGND VGND VGND VGND sky130_fd_pr__nfet_g5v0d10v5 ad=1.45 pd=10.58 as=0 ps=0 w=5 l=2
X51 a_12303_15620.n11 a_9555_19880.n75 VGND VGND sky130_fd_pr__nfet_g5v0d10v5 ad=0.725 pd=5.29 as=0.725 ps=5.29 w=5 l=2
X52 VGND a_18115_18320.t0 a_18049_18522.t0 VGND sky130_fd_pr__nfet_g5v0d10v5 ad=0.17887 pd=1.26 as=0.1197 ps=1.41 w=0.42 l=0.5
X53 a_9155_15594.n82 ua[1] a_9097_18714.n43 VAPWR sky130_fd_pr__pfet_g5v0d10v5 ad=0.725 pd=5.29 as=0.725 ps=5.29 w=5 l=2
X54 VAPWR VAPWR VAPWR VAPWR sky130_fd_pr__pfet_g5v0d10v5 ad=0.725 pd=5.29 as=0 ps=0 w=5 l=2
X55 VGND a_18049_18522.t0 a_18059_19108.t0 VGND sky130_fd_pr__nfet_g5v0d10v5 ad=0.19875 pd=2.03 as=0.19875 ps=2.03 w=0.75 l=0.5
X56 a_8249_23526.n69 a_8249_23526.n69 VAPWR VAPWR sky130_fd_pr__pfet_g5v0d10v5 ad=1.45 pd=10.58 as=1.45 ps=10.58 w=5 l=2
X57 a_12303_18714.n82 a_12303_18714.n82 VGND VGND sky130_fd_pr__nfet_g5v0d10v5 ad=0.725 pd=5.29 as=0.725 ps=5.29 w=5 l=2
X58 VAPWR a_8249_23526.n69 a_9097_18714.n43 VAPWR sky130_fd_pr__pfet_g5v0d10v5 ad=0.725 pd=5.29 as=0.725 ps=5.29 w=5 l=2
X59 a_9097_18714.n43 a_8249_23526.n69 VAPWR VAPWR sky130_fd_pr__pfet_g5v0d10v5 ad=0.725 pd=5.29 as=0.725 ps=5.29 w=5 l=2
X60 VAPWR a_8825_23526.t0 a_9225_23623.n35 VAPWR sky130_fd_pr__pfet_g5v0d10v5 ad=1.45 pd=10.58 as=0.725 ps=5.29 w=5 l=2
X61 VGND VGND VGND VGND sky130_fd_pr__nfet_g5v0d10v5 ad=0.725 pd=5.29 as=0 ps=0 w=5 l=2
X62 VAPWR a_9555_15620.n77 a_12303_15620.n11 VAPWR sky130_fd_pr__pfet_g5v0d10v5 ad=0.725 pd=5.29 as=0.725 ps=5.29 w=5 l=2
X63 VAPWR VAPWR a_9097_18714.n43 VAPWR sky130_fd_pr__pfet_g5v0d10v5 ad=0.725 pd=5.29 as=0.725 ps=5.29 w=5 l=2
X64 VGND a_9155_15594.n82 a_9155_15594.n82 VGND sky130_fd_pr__nfet_g5v0d10v5 ad=0.725 pd=5.29 as=0.725 ps=5.29 w=5 l=2
X65 VAPWR VAPWR VAPWR VAPWR sky130_fd_pr__pfet_g5v0d10v5 ad=0.725 pd=5.29 as=0 ps=0 w=5 l=2
X66 VAPWR a_12303_16782.t0 a_12303_16782.t0 VAPWR sky130_fd_pr__pfet_g5v0d10v5 ad=0.725 pd=5.29 as=0.725 ps=5.29 w=5 l=2
X67 a_18355_19224.t0 a_18059_19108.t0 VDPWR VDPWR sky130_fd_pr__pfet_01v8_hvt ad=0.2968 pd=2.77 as=0.1568 ps=1.4 w=1.12 l=0.15
X68 a_9097_16782.t0 ua[0] a_12303_16782.t0 VGND sky130_fd_pr__nfet_g5v0d10v5 ad=0.725 pd=5.29 as=0.725 ps=5.29 w=5 l=2
X69 a_18115_18320.t0 a_16801_16782.n62 VAPWR VAPWR sky130_fd_pr__pfet_g5v0d10v5 ad=0.1113 pd=1.37 as=0.1197 ps=1.41 w=0.42 l=0.5
X70 a_9097_18714.n43 ua[1] a_9155_15594.n82 VAPWR sky130_fd_pr__pfet_g5v0d10v5 ad=0.725 pd=5.29 as=0.725 ps=5.29 w=5 l=2
X71 a_9155_15594.n82 ua[1] a_9097_18714.n43 VAPWR sky130_fd_pr__pfet_g5v0d10v5 ad=0.725 pd=5.29 as=0.725 ps=5.29 w=5 l=2
X72 a_9097_18714.n43 VAPWR VAPWR VAPWR sky130_fd_pr__pfet_g5v0d10v5 ad=0.725 pd=5.29 as=0.725 ps=5.29 w=5 l=2
X73 a_9155_19783.t0 a_9155_19783.t0 VAPWR VAPWR sky130_fd_pr__pfet_g5v0d10v5 ad=0.725 pd=5.29 as=0.725 ps=5.29 w=5 l=2
X74 a_9225_23623.n35 a_8825_23526.t0 VAPWR VAPWR sky130_fd_pr__pfet_g5v0d10v5 ad=0.725 pd=5.29 as=1.45 ps=10.58 w=5 l=2
X75 VGND a_16801_16782.n62 a_18115_18320.t0 VGND sky130_fd_pr__nfet_g5v0d10v5 ad=0.17887 pd=1.26 as=0.1197 ps=1.41 w=0.42 l=0.5
X76 a_13355_22717.t0 a_17815_23247.t0 VAPWR sky130_fd_pr__res_high_po_1p41 l=20.3
X77 VAPWR VAPWR VAPWR VAPWR sky130_fd_pr__pfet_g5v0d10v5 ad=0.725 pd=5.29 as=0 ps=0 w=5 l=2
X78 a_9555_19880.n75 a_9155_19783.t0 VAPWR VAPWR sky130_fd_pr__pfet_g5v0d10v5 ad=0.725 pd=5.29 as=0.725 ps=5.29 w=5 l=2
X79 a_9097_16782.t0 ua[0] a_12303_16782.t0 VGND sky130_fd_pr__nfet_g5v0d10v5 ad=0.725 pd=5.29 as=0.725 ps=5.29 w=5 l=2
X80 a_8697_16756.n174 a_9225_23623.n35 a_8825_23526.t0 VAPWR sky130_fd_pr__pfet_g5v0d10v5 ad=0.725 pd=5.29 as=1.45 ps=10.58 w=5 l=2
X81 a_8825_23526.t0 a_9225_23623.n35 a_8697_16756.n174 VAPWR sky130_fd_pr__pfet_g5v0d10v5 ad=0.725 pd=5.29 as=0.725 ps=5.29 w=5 l=2
X82 VAPWR a_17813_24307.t0 VAPWR sky130_fd_pr__res_high_po_1p41 l=20.3
X83 VAPWR a_12303_15620.n11 a_15885_16782.n80 VAPWR sky130_fd_pr__pfet_g5v0d10v5 ad=1.45 pd=10.29 as=2.9 ps=20.58 w=10 l=2
X84 a_16801_16782.n62 a_15885_16782.n80 VAPWR VAPWR sky130_fd_pr__pfet_g5v0d10v5 ad=2.9 pd=20.58 as=1.45 ps=10.29 w=10 l=2
X85 a_8825_23526.t0 a_9225_23623.n35 a_8697_16756.n174 VAPWR sky130_fd_pr__pfet_g5v0d10v5 ad=1.45 pd=10.58 as=0.725 ps=5.29 w=5 l=2
X86 a_9225_23623.n35 VGND VGND VGND sky130_fd_pr__nfet_g5v0d10v5 ad=0.725 pd=5.29 as=0.725 ps=5.29 w=5 l=2
X87 a_9155_19783.t0 ua[1] a_9097_16782.t0 VGND sky130_fd_pr__nfet_g5v0d10v5 ad=0.725 pd=5.29 as=0.725 ps=5.29 w=5 l=2
X88 a_18355_19224.t0 a_18115_18320.t0 VGND VGND sky130_fd_pr__nfet_g5v0d10v5 ad=0.105 pd=1.03 as=0.17887 ps=1.26 w=0.75 l=0.5
X89 a_12303_15620.n11 a_12303_16782.t0 VAPWR VAPWR sky130_fd_pr__pfet_g5v0d10v5 ad=0.725 pd=5.29 as=0.725 ps=5.29 w=5 l=2
X90 a_18059_19108.t0 a_18049_18522.t0 VGND VGND sky130_fd_pr__nfet_g5v0d10v5 ad=0.105 pd=1.03 as=0.17887 ps=1.26 w=0.75 l=0.5
X91 a_9097_16782.t0 a_8697_16756.n174 VGND VGND sky130_fd_pr__nfet_g5v0d10v5 ad=0.725 pd=5.29 as=0.725 ps=5.29 w=5 l=2
X92 VDPWR a_18059_19108.t0 uo_out[0] VDPWR sky130_fd_pr__pfet_01v8_hvt ad=0.1568 pd=1.4 as=0.2968 ps=2.77 w=1.12 l=0.15
X93 VGND a_8697_16756.n174 a_9097_16782.t0 VGND sky130_fd_pr__nfet_g5v0d10v5 ad=0.725 pd=5.29 as=0.725 ps=5.29 w=5 l=2
X94 VAPWR VAPWR VAPWR VAPWR sky130_fd_pr__pfet_g5v0d10v5 ad=1.45 pd=10.58 as=0 ps=0 w=5 l=2
X95 VAPWR VAPWR VAPWR VAPWR sky130_fd_pr__pfet_g5v0d10v5 ad=0.725 pd=5.29 as=0 ps=0 w=5 l=2
X96 a_12303_18714.n82 ua[0] a_9097_18714.n43 VAPWR sky130_fd_pr__pfet_g5v0d10v5 ad=0.725 pd=5.29 as=0.725 ps=5.29 w=5 l=2
X97 a_13355_21657.t0 a_17815_22187.t0 VAPWR sky130_fd_pr__res_high_po_1p41 l=20.3
X98 VAPWR a_9155_19783.t0 a_9555_19880.n75 VAPWR sky130_fd_pr__pfet_g5v0d10v5 ad=0.725 pd=5.29 as=0.725 ps=5.29 w=5 l=2
X99 a_9555_15620.n77 a_9555_15620.n77 VAPWR VAPWR sky130_fd_pr__pfet_g5v0d10v5 ad=0.725 pd=5.29 as=0.725 ps=5.29 w=5 l=2
X100 VGND VGND a_9097_16782.t0 VGND sky130_fd_pr__nfet_g5v0d10v5 ad=0.725 pd=5.29 as=0.725 ps=5.29 w=5 l=2
X101 a_12303_18714.n82 ua[0] a_9097_18714.n43 VAPWR sky130_fd_pr__pfet_g5v0d10v5 ad=0.725 pd=5.29 as=0.725 ps=5.29 w=5 l=2
X102 VAPWR a_9555_15620.n77 a_9555_15620.n77 VAPWR sky130_fd_pr__pfet_g5v0d10v5 ad=0.725 pd=5.29 as=0.725 ps=5.29 w=5 l=2
X103 VGND VGND VGND VGND sky130_fd_pr__nfet_g5v0d10v5 ad=0.725 pd=5.29 as=0 ps=0 w=5 l=2
X104 a_18049_18522.t0 a_18115_18320.t0 VAPWR VAPWR sky130_fd_pr__pfet_g5v0d10v5 ad=0.1113 pd=1.37 as=0.1197 ps=1.41 w=0.42 l=0.5
X105 a_8249_23526.n69 VGND VGND VGND sky130_fd_pr__nfet_g5v0d10v5 ad=0.725 pd=5.29 as=1.45 ps=10.58 w=5 l=2
X106 a_9097_16782.t0 VGND VGND VGND sky130_fd_pr__nfet_g5v0d10v5 ad=0.725 pd=5.29 as=0.725 ps=5.29 w=5 l=2
.ends
